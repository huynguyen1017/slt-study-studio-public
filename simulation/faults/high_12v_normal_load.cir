* Fault injection educational hypothetical: model not physical board
* high_12v_normal_load input=12.0 V, Rdriver 20 ohm, Radded 33 ohm, load 200.0 ohm
Vstep vs 0 PULSE(0 12.0 1n 0.1n 0.1n 45n 90n)
Rdriver vs tx 20
Radded tx p 33
Ltrace p rx 10n
Cpin rx 0 30p
Rload rx 0 200.0
.tran 0.02n 16n 0 0.02n
.control
set wr_singlescale
set wr_vecnames
run
wrdata high_12v_normal_load.dat v(vs) v(tx) v(p) v(rx) i(Ltrace)
quit
.endc
.end
