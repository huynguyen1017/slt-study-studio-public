* SLT educational PCB circuit: transient analysis
* Source=1.8 V, added series R=0 ohm, L=10nH, C=30pF, MOS switch enabled=1
Vsrc vs 0 PULSE(0 1.8 1n 0.10n 0.10n 40n 80n)
Rdriver vs tx 20
Rseries tx p 0.1
Ltrace p rx 10n
Cload rx 0 30p
Rload rx 0 200
Vgate gate 0 PULSE(0 3.3 8n 0.2n 0.2n 30n 60n)
Mpull rx gate 0 0 SWNM W=150u L=1u
.model SWNM NMOS LEVEL=1 VTO=1.1 KP=0.0001 LAMBDA=0.01
.tran 0.02n 16n 0 0.02n
.control
set wr_singlescale
set wr_vecnames
run
wrdata b39.dat v(vs) v(tx) v(p) v(rx) v(gate) i(Ltrace)
quit
.endc
.end
